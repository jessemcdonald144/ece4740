ADE simulation setup
Run mode: Single Run, Sweeps and Corners
Tests:
  ECE4740_Lab4_bitcell_tb_1: final/bitcell_tb/config, simulator spectre
    Variables: Te_eval = 500p; Te_we = 400p; Te_WL_r = 400p; Te_WL_w = 400p; Tpre_r = 100p; Tpre_w = 100p; TR = 600p; Tst_eval = 300p; Tst_we = 200p; Tst_WL_r = 200p; Tst_WL_w = 300p; TW = 600p; vdd = 1
    Outputs: "/I23/bitcell_V"; /I20/bitcell_V
