ADE simulation setup
Test ECE4740_Lab4_bitcell_tb_1: final/bitcell_tb/config, simulator spectre
  Models: /opt/cadence-designkits/gpdk045_v_6_0/gpdk045/../models/spectre/gpdk045.scs[mc]
  Variables: Te_eval = 500p; Te_we = 400p; Te_WL_r = 400p; Te_WL_w = 400p; Tpre_r = 100p; Tpre_w = 100p; Tst_eval = 300p; Tst_we = 200p; Tst_WL_r = 200p; Tst_WL_w = 300p; vdd = 1; TR = 600p; TW = 600p
  Temperature: 27
  Simulator options: tnom=25
  Analysis tran: stop=10n errpreset=conservative
  Signals: /WL, /EQ, /CSEL, /Vn, /Vp, /IO, /IO_star, /BL1, /BL1_star, /I20/bitcell_V, /w_ena, /ISO1, /ISO2, /I22/CSEL_b, /I22/net1
Run mode: Single Run, Sweeps and Corners
